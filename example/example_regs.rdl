addrmap example_regs {
    name = "btl example regs";
    desc = "Registers for the btl example code";
    default regwidth = 32;
    default reset = 0;
    default sw = rw;
    default hw = rw;  

    reg {
        name = "csr_a";
        desc = "Example csr";    

        field { } power_state[2:0] = 3'b101;

        field {
            name = "Error Status";
            onwrite = woclr;
        } error_status[7:3] = 5'h0;

        field {
            name = "Message";
            desc = "For exchanging messages between hw and sw";
        } message[31:8] = 24'h0;    
    } csr_a @ 0x0;

    reg {
        name = "csr_b";
        desc = "Another example csr";    

        field {
            name = "ID";
            desc = "Read-only ID";
            sw = r;
        } ID[7:0] = 8'h0;

        field {
            name = "Class ID";
            desc = "Read-only device class";
            sw = r;
        } class_id[15:8] = 8'h0;

        field {
            name = "Version";
            desc = "Read-only device version";
            sw = r;
        } version[23:16] = 8'h0;

        field {
            name = "Enable";      
            desc = "Write 1 to enable device, 0 to disable";
        } enable[24:24] = 1'b0;
    } csr_b @ 0x4;  
};
